; Fill in the PSF directory and result names before running.
openResults("YOUR_RESULTS_DIR")

selectResult('dc)
ocnPrint(
  ?output "YOUR_DC_CSV"
  v("YOUR_OUTPUT_NET")
  v("YOUR_SWEEP_NET")
)

selectResult('tran)
ocnPrint(
  ?output "YOUR_TRAN_CSV"
  v("YOUR_OUTPUT_NET")
  v("YOUR_INPUT_NET")
)

exit()
